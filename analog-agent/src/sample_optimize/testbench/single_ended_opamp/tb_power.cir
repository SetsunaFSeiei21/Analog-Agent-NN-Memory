* Single-ended op-amp quiescent power: ACDC-reference unity-gain follower.
* DUT interface: .subckt DUT VINP VINN VOUT VDD VSS
* The reference conditions use TEMP=25, matching its FIND ... AT=25.
* Only an operating point is needed: a capacitor is open in this analysis.
* TC and Vos are outside the repository's nine-metric output contract.

.lib "{{PDK_PATH}}" {{CORNER}}
.include "{{DUT_PATH}}"
.temp {{TEMP}}

VDD_SRC VDD 0 DC {{VDD}}
VSS_SRC VSS 0 DC {{VSS}}
VINP_SRC INP 0 DC {{VCM}}
XDUT INP OUT OUT VDD VSS DUT
.op

.control
set wr_singlescale
set wr_vecnames
option numdgt=15
run
let vout_dc = v(OUT)
let follower_error_v = v(OUT) - v(INP)
let idd_a = -i(VDD_SRC)
let iss_a = i(VSS_SRC)
let idd_ua = idd_a * 1e6
let iss_ua = iss_a * 1e6
let p_vdd_w = -v(VDD) * i(VDD_SRC)
let p_vss_w = -v(VSS) * i(VSS_SRC)
let power_w = p_vdd_w + p_vss_w
let p_vdd_uw = p_vdd_w * 1e6
let p_vss_uw = p_vss_w * 1e6
let power_uw = power_w * 1e6
print vout_dc follower_error_v idd_a iss_a idd_ua iss_ua p_vdd_uw p_vss_uw power_uw
wrdata {{OUTPUT_PATH}} idd_ua iss_ua p_vdd_uw p_vss_uw power_uw
quit
.endc
.end
