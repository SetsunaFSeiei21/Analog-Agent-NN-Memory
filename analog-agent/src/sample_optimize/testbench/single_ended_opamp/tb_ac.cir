* Single-ended op-amp AC test: ACDC-reference feedback/injection circuit.
* DUT interface: .subckt DUT VINP VINN VOUT VDD VSS
* DC: LFB closes negative feedback; CINJ is open.
* AC: LFB is open; CINJ applies 1 V to the inverting input.
* This matches opout/opout_dc/signal_in in the supplied ACDC deck.
* Keep signed gain in dB; a negative dB value is not a positive gain.

.lib "{{PDK_PATH}}" {{CORNER}}
.include "{{DUT_PATH}}"
.temp {{TEMP}}

VDD_SRC VDD 0 DC {{VDD}}
VSS_SRC VSS 0 DC {{VSS}}
VINP_SRC INP 0 DC {{VCM}}
VINJ SIGNAL_IN 0 DC {{VCM}} AC 1
LFB OUT INN 1T
CINJ INN SIGNAL_IN 1T
XDUT INP INN OUT VDD VSS DUT
CLOAD OUT VSS {{CL}}

.ac dec {{AC_POINTS_PER_DEC}} {{AC_START}} {{AC_STOP}}

.control
set wr_singlescale
set wr_vecnames
option numdgt=15
op
let vout_dc = v(OUT)
let follower_error_v = v(OUT) - v(INP)
print vout_dc follower_error_v
run

* Correct the inverting injection sign and normalize by the actual input.
let differential_input = v(INP) - v(INN)
let open_loop_gain = v(OUT) / differential_input
let gain_db = db(open_loop_gain)
let phase_deg = 180/pi*cph(open_loop_gain)

* Raw ACDC-platform output transfer, for direct comparison with dcgain_.
let reference_transfer_db = db(v(OUT) / v(SIGNAL_IN))
meas ac reference_gain_db FIND reference_transfer_db AT={{GAIN_MEASURE_FREQ}}
meas ac dc_gain_db FIND gain_db AT={{GAIN_MEASURE_FREQ}}
meas ac gbw_hz WHEN gain_db=0 FALL=1
print reference_gain_db dc_gain_db gbw_hz
wrdata {{OUTPUT_PATH}} gain_db phase_deg reference_transfer_db
quit
.endc
.end
