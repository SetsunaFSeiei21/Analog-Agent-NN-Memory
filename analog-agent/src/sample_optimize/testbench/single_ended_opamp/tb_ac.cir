* ============================================================
* Generic Single-Ended OpAmp AC Testbench
*
* Standard DUT interface:
*
* .subckt DUT VINP VINN VOUT VDD VSS
*
* Metrics:
*   DC Gain
*   UGF
*
* Phase Margin is measured only by tb_stability.cir.
* ============================================================

* ============================================================
* PDK
* ============================================================

.lib "{{PDK_PATH}}" {{CORNER}}

* ============================================================
* DUT
* ============================================================

.include "{{DUT_PATH}}"

* ============================================================
* Simulation Conditions
* ============================================================

.temp {{TEMP}}

* ============================================================
* Supply
* ============================================================

VDD_SRC VDD 0 DC {{VDD}}

VSS_SRC VSS 0 DC {{VSS}}

* ============================================================
* Differential AC Excitation
*
* VINP = +0.5 V AC
* VINN = -0.5 V AC
*
* Differential AC input:
*
* VINP - VINN = 1 V
* ============================================================

VINP_SRC INP 0 DC {{VCM}} AC 0.5 0

VINN_SRC INN 0 DC {{VCM}} AC 0.5 180

* ============================================================
* DUT
* ============================================================

XDUT INP INN OUT VDD VSS DUT

* ============================================================
* Output Load
* ============================================================

CLOAD OUT VSS {{CL}}

* ============================================================
* AC Analysis
* ============================================================

.ac dec {{AC_POINTS_PER_DEC}} {{AC_START}} {{AC_STOP}}

* ============================================================
* Control
* ============================================================

.control

run

set wr_singlescale
set wr_vecnames
option numdgt=15

* ============================================================
* Open-Loop Gain
* ============================================================

let differential_input = v(INP) - v(INN)

let open_loop_gain = v(OUT) / differential_input

let gain_db = db(open_loop_gain)

let phase_deg = 180/pi*cph(open_loop_gain)

* ============================================================
* Low-Frequency Gain
* ============================================================

meas ac dc_gain_db FIND gain_db AT={{GAIN_MEASURE_FREQ}}

* ============================================================
* Unity-Gain Frequency
*
* The measurement fails when the low-frequency gain is below
* 0 dB or when no falling 0-dB crossing exists. Such a design
* point is treated as an invalid amplifier sizing.
* ============================================================

meas ac gbw_hz WHEN gain_db=0 FALL=1

* ============================================================
* Output
* ============================================================

echo ========================================
echo AC PERFORMANCE
echo ========================================

print dc_gain_db

print gbw_hz

* ============================================================
* Save Full AC Response
*
* phase_deg is retained only for waveform inspection.
* It is not used as the final Phase Margin metric.
* ============================================================

wrdata "{{OUTPUT_PATH}}" gain_db phase_deg

quit

.endc

.end
