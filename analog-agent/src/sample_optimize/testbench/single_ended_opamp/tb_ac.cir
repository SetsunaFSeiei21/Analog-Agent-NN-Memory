* ============================================================
* Generic Single-Ended OpAmp AC Testbench
*
* Standard DUT interface:
*
* .subckt DUT VINP VINN VOUT VDD VSS IBIAS
*
* Metrics:
*   DC Gain
*   GBW
*   Phase Margin
* ============================================================

* ============================================================
* PDK
* ============================================================

.lib "{{PDK_PATH}}" {{CORNER}}

* ============================================================
* DUT
* ============================================================

.include "{{DUT_PATH}}"

* ============================================================
* Simulation Conditions
* ============================================================

.temp {{TEMP}}

* ============================================================
* Supply
* ============================================================

VDD_SRC VDD 0 DC {{VDD}}

* ============================================================
* Bias Current
*
* Positive IBIAS flows:
*
* VDD -> IBIAS -> DUT
* ============================================================

IBIAS_SRC VDD IBIAS DC {{IBIAS}}

* ============================================================
* Differential AC Excitation
*
* VINP = +0.5 V AC
* VINN = -0.5 V AC
*
* Differential AC input magnitude = 1 V
* ============================================================

VINP_SRC INP 0 DC {{VCM}} AC 0.5 0

VINN_SRC INN 0 DC {{VCM}} AC 0.5 180

* ============================================================
* DUT
* ============================================================

XDUT INP INN OUT VDD 0 IBIAS DUT

* ============================================================
* Output Load
* ============================================================

CLOAD OUT 0 {{CL}}

* ============================================================
* AC Analysis
* ============================================================

.ac dec {{AC_POINTS_PER_DEC}} {{AC_START}} {{AC_STOP}}

* ============================================================
* Control
* ============================================================

.control

run

set wr_singlescale
set wr_vecnames
option numdgt=15

* ============================================================
* Derived Vectors
* ============================================================

let gain_db = db(v(OUT))

let phase_deg = 180/pi*phase(v(OUT))

* ============================================================
* Low-Frequency Gain
* ============================================================

meas ac dc_gain_db FIND gain_db AT={{GAIN_MEASURE_FREQ}}

* ============================================================
* GBW
* ============================================================

meas ac gbw_hz WHEN gain_db=0 FALL=1

* ============================================================
* Phase at GBW
* ============================================================

meas ac phase_at_gbw_deg FIND phase_deg WHEN gain_db=0 FALL=1

* ============================================================
* Phase Margin
* ============================================================

let phase_margin_deg = 180 + phase_at_gbw_deg

* ============================================================
* Output
* ============================================================

echo ========================================
echo AC PERFORMANCE
echo ========================================

print dc_gain_db
print gbw_hz
print phase_at_gbw_deg
print phase_margin_deg

* ============================================================
* Save Full Response
* ============================================================

wrdata "{{OUTPUT_PATH}}" gain_db phase_deg

quit

.endc

.end
