* Single-ended op-amp slew rate: unity-gain follower, pulse excitation.
* DUT interface: .subckt DUT VINP VINN VOUT VDD VSS
* The supplied ACDC deck has no transient slew-rate measurement.
* Retain the repository pulse method and use the same bias/load profile.
* SR = 0.8 * settled output swing / transition time, reported in V/us.

.lib "{{PDK_PATH}}" {{CORNER}}
.include "{{DUT_PATH}}"
.temp {{TEMP}}

VDD_SRC VDD 0 DC {{VDD}}
VSS_SRC VSS 0 DC {{VSS}}
VIN_SRC IN 0 PULSE({{VIN_LOW}} {{VIN_HIGH}} {{PULSE_DELAY}} {{INPUT_TR}} {{INPUT_TF}} {{PULSE_WIDTH}} {{PULSE_PERIOD}})
XDUT IN OUT OUT VDD VSS DUT
VLOAD_REF LOAD_REF 0 DC {{LOAD_REF}}
RLOAD OUT LOAD_REF {{RL}}
CLOAD OUT LOAD_REF {{CL}}
.tran {{TRAN_STEP}} {{TRAN_STOP}} 0 {{TRAN_MAX_STEP}}

.control
set wr_singlescale
set wr_vecnames
option numdgt=15
run
meas tran vout_low AVG v(OUT) FROM={{LOW_AVG_START}} TO={{LOW_AVG_STOP}}
meas tran vout_high AVG v(OUT) FROM={{HIGH_AVG_START}} TO={{HIGH_AVG_STOP}}
let vout_swing = vout_high - vout_low
let vout_10 = vout_low + 0.1 * vout_swing
let vout_90 = vout_low + 0.9 * vout_swing

* Search TRIG and TARG in the same transition; exclude the earlier edge.
meas tran rise_10_90 TRIG v(OUT) VAL=vout_10 TD={{RISE_SEARCH_START}} RISE=1 TARG v(OUT) VAL=vout_90 TD={{RISE_SEARCH_START}} RISE=1
meas tran fall_90_10 TRIG v(OUT) VAL=vout_90 TD={{FALL_SEARCH_START}} FALL=1 TARG v(OUT) VAL=vout_10 TD={{FALL_SEARCH_START}} FALL=1

* Omit results for a reversed swing or a non-positive measurement interval.
* Missing metrics are handled by Simulator's existing continue_on_error path.
if (vout_swing > 0)
    let slew_delta_v = 0.8 * vout_swing
    if (rise_10_90 > 0)
        let slew_rise_v_us = slew_delta_v / rise_10_90 / 1e6
        print slew_rise_v_us
    else
        echo INVALID_SLEW_RISE: non-positive measurement interval
    end
    if (fall_90_10 > 0)
        let slew_fall_v_us = slew_delta_v / fall_90_10 / 1e6
        print slew_fall_v_us
    else
        echo INVALID_SLEW_FALL: non-positive measurement interval
    end
else
    echo INVALID_SLEW: non-positive output swing
end
print vout_low vout_high vout_swing rise_10_90 fall_90_10
wrdata {{OUTPUT_PATH}} v(IN) v(OUT)
quit
.endc
.end
