* Single-ended op-amp PSRR: ACDC-reference unity-gain followers.
* DUT interface: .subckt DUT VINP VINN VOUT VDD VSS
* Excite one rail by 1 V AC while both input references stay quiet.
* The output load returns to node 0, matching the supplied ACDC deck.
* Report rejection in dB, rather than the raw output transfer in dB.

.lib "{{PDK_PATH}}" {{CORNER}}
.include "{{DUT_PATH}}"
.temp {{TEMP}}

VDD_P_SRC VDD_P 0 DC {{VDD}} AC 1
VSS_P_SRC VSS_P 0 DC {{VSS}}
VINP_P_SRC INP_P 0 DC {{VCM}}
XDUT_P INP_P OUT_P OUT_P VDD_P VSS_P DUT
CLOAD_P OUT_P 0 {{CL}}

VDD_N_SRC VDD_N 0 DC {{VDD}}
VSS_N_SRC VSS_N 0 DC {{VSS}} AC 1
VINP_N_SRC INP_N 0 DC {{VCM}}
XDUT_N INP_N OUT_N OUT_N VDD_N VSS_N DUT
CLOAD_N OUT_N 0 {{CL}}

.ac dec {{AC_POINTS_PER_DEC}} {{AC_START}} {{AC_STOP}}

.control
set wr_singlescale
set wr_vecnames
option numdgt=15
op
let psrr_plus_vout_dc = v(OUT_P)
let psrr_minus_vout_dc = v(OUT_N)
print psrr_plus_vout_dc psrr_minus_vout_dc
run
let vos_plus = v(INP_P) - v(OUT_P)
let vos_minus = v(INP_N) - v(OUT_N)
let psrr_plus = v(VDD_P) / vos_plus
let psrr_minus = v(VSS_N) / vos_minus
let psrr_plus_db = db(psrr_plus)
let psrr_minus_db = db(psrr_minus)
let reference_psrr_plus_transfer_db = db(v(OUT_P) / v(VDD_P))
let reference_psrr_minus_transfer_db = db(v(OUT_N) / v(VSS_N))
meas ac psrr_plus_ref_db FIND psrr_plus_db AT={{PSRR_MEASURE_FREQ}}
meas ac psrr_minus_ref_db FIND psrr_minus_db AT={{PSRR_MEASURE_FREQ}}
meas ac reference_psrr_plus_db FIND reference_psrr_plus_transfer_db AT={{PSRR_MEASURE_FREQ}}
meas ac reference_psrr_minus_db FIND reference_psrr_minus_transfer_db AT={{PSRR_MEASURE_FREQ}}
print psrr_plus_ref_db psrr_minus_ref_db reference_psrr_plus_db reference_psrr_minus_db
wrdata {{OUTPUT_PATH}} psrr_plus_db psrr_minus_db reference_psrr_plus_transfer_db reference_psrr_minus_transfer_db
quit
.endc
.end
