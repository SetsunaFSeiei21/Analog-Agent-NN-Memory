* Single-ended op-amp stability test: same ACDC injection as tb_ac.cir.
* DUT interface: .subckt DUT VINP VINN VOUT VDD VSS
* DC negative feedback is closed through LFB; AC feedback is broken.
* Loop gain L = -VOUT/VINN for the unity-feedback configuration.
* Phase margin is 180 + phase(L) at the first falling unity-gain crossing.

.lib "{{PDK_PATH}}" {{CORNER}}
.include "{{DUT_PATH}}"
.temp {{TEMP}}

VDD_SRC VDD 0 DC {{VDD}}
VSS_SRC VSS 0 DC {{VSS}}
VINP_SRC INP 0 DC {{VCM}}
VINJ SIGNAL_IN 0 DC {{VCM}} AC 1
LFB OUT INN 1T
CINJ INN SIGNAL_IN 1T
XDUT INP INN OUT VDD VSS DUT
CLOAD OUT VSS {{CL}}

.ac dec {{AC_POINTS_PER_DEC}} {{AC_START}} {{AC_STOP}}

.control
set wr_singlescale
set wr_vecnames
option numdgt=15
op
let vout_dc = v(OUT)
let follower_error_v = v(OUT) - v(INP)
print vout_dc follower_error_v
run
let loop_gain = -v(OUT) / v(INN)
let loop_gain_db = db(loop_gain)
let loop_phase_deg = 180/pi*cph(loop_gain)
let reference_transfer_phase_deg = 180/pi*ph(v(OUT) / v(SIGNAL_IN))
meas ac loop_ugf_hz WHEN loop_gain_db=0 FALL=1
meas ac phase_at_ugf_deg FIND loop_phase_deg WHEN loop_gain_db=0 FALL=1
let phase_margin_deg = 180 + phase_at_ugf_deg
print loop_ugf_hz phase_at_ugf_deg phase_margin_deg
wrdata {{OUTPUT_PATH}} loop_gain_db loop_phase_deg reference_transfer_phase_deg
quit
.endc
.end
