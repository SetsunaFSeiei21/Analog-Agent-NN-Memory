* Opamp1 - Sky130 1.8-V operational amplifier
* W and L are in um under the Sky130 scale=1u convention.

.include "Opamp1_params.sp"

.subckt DUT VINP VINN VOUT VDD VSS

XPM12 VB1 NET4 VDD VDD sky130_fd_pr__pfet_01v8 W={DESVAR_W4} L={DESVAR_L4} m=1
XPM11 NET4 NET4 VDD VDD sky130_fd_pr__pfet_01v8 W={DESVAR_W4} L={DESVAR_L4} m=1
XPM10 NET3 VB2 VDD VDD sky130_fd_pr__pfet_01v8 W={DESVAR_W2} L={DESVAR_L2} m=1
XPM8 VB2 VB2 NET3 VDD sky130_fd_pr__pfet_01v8 W={DESVAR_W2} L={DESVAR_L2} m={DESVAR_M2}

XM10 NET2 VB2 NET27 VDD sky130_fd_pr__pfet_01v8 W={DESVAR_W7} L={DESVAR_L7} m={DESVAR_M1}
XM15 VOUT VB2 NET24 VDD sky130_fd_pr__pfet_01v8 W={DESVAR_W7} L={DESVAR_L7} m={DESVAR_M1}
XM9 NET27 NET2 VDD VDD sky130_fd_pr__pfet_01v8 W={DESVAR_W8} L={DESVAR_L8} m={DESVAR_M1}
XM5 NET24 NET2 VDD VDD sky130_fd_pr__pfet_01v8 W={DESVAR_W8} L={DESVAR_L8} m={DESVAR_M1}
XM16 NET11 VB2 NET25 VDD sky130_fd_pr__pfet_01v8 W={DESVAR_W7} L={DESVAR_L7} m={DESVAR_M1}
XM14 NET6 VB2 NET26 VDD sky130_fd_pr__pfet_01v8 W={DESVAR_W7} L={DESVAR_L7} m={DESVAR_M1}
XM8 NET26 NET6 VDD VDD sky130_fd_pr__pfet_01v8 W={DESVAR_W8} L={DESVAR_L8} m={DESVAR_M1}
XM6 NET25 NET6 VDD VDD sky130_fd_pr__pfet_01v8 W={DESVAR_W8} L={DESVAR_L8} m={DESVAR_M1}

XNM10 NET5 VB1 VSS VSS sky130_fd_pr__nfet_01v8 W={DESVAR_W5} L={DESVAR_L5} m=1
XNM9 VB1 VB1 NET5 VSS sky130_fd_pr__nfet_01v8 W={DESVAR_W5} L={DESVAR_L5} m={DESVAR_M3}
XNM8 NET4 VB3 VSS VSS sky130_fd_pr__nfet_01v8 W={DESVAR_W1} L={DESVAR_L1} m=1
XNM7 VB3 VB3 VSS VSS sky130_fd_pr__nfet_01v8 W={DESVAR_W1} L={DESVAR_L1} m=1
XNM6 VB2 VB3 VSS VSS sky130_fd_pr__nfet_01v8 W={DESVAR_W1} L={DESVAR_L1} m=1

XM13 NET23 NET11 VSS VSS sky130_fd_pr__nfet_01v8 W={DESVAR_W10} L={DESVAR_L10} m={DESVAR_M1}
XM7 NET22 NET11 VSS VSS sky130_fd_pr__nfet_01v8 W={DESVAR_W10} L={DESVAR_L10} m={DESVAR_M1}
XM1 NET11 VB1 NET22 VSS sky130_fd_pr__nfet_01v8 W={DESVAR_W9} L={DESVAR_L9} m={DESVAR_M1}
XNM5 NET1 VB3 VSS VSS sky130_fd_pr__nfet_01v8 W={DESVAR_W1} L={DESVAR_L1} m={2*DESVAR_M1}
XM0 VOUT VB1 NET23 VSS sky130_fd_pr__nfet_01v8 W={DESVAR_W9} L={DESVAR_L9} m={DESVAR_M1}
XM11 NET2 VINP NET1 VSS sky130_fd_pr__nfet_01v8 W={DESVAR_W6} L={DESVAR_L6} m={DESVAR_M1}
XM12 NET6 VINN NET1 VSS sky130_fd_pr__nfet_01v8 W={DESVAR_W6} L={DESVAR_L6} m={DESVAR_M1}

IBIAS_SRC VDD VB3 DC {IBIAS_A}

.ends DUT
