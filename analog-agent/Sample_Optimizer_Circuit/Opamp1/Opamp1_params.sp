* ============================================================
* Opamp1_params.sp
*
* Design parameters for Opamp1
*
* Units:
*   W, L    -> um
*   IBIAS_A -> A
*   M       -> dimensionless positive integer
* ============================================================

.param DESVAR_W1=5.0
.param DESVAR_L1=0.5

.param DESVAR_W2=5.0
.param DESVAR_L2=0.5

.param DESVAR_W4=5.0
.param DESVAR_L4=0.5

.param DESVAR_W5=5.0
.param DESVAR_L5=0.5

.param DESVAR_W6=5.0
.param DESVAR_L6=0.5

.param DESVAR_W7=5.0
.param DESVAR_L7=0.5

.param DESVAR_W8=5.0
.param DESVAR_L8=0.5

.param DESVAR_W9=5.0
.param DESVAR_L9=0.5

.param DESVAR_W10=5.0
.param DESVAR_L10=0.5

.param DESVAR_M1=1
.param DESVAR_M2=5
.param DESVAR_M3=5

.param IBIAS_A=10e-6
