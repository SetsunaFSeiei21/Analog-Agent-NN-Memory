* Opamp6 nominal sizing: W/L in um, M dimensionless, IBIAS_A in A.
* 25 independent parameters: 9 W + 9 L + 6 M + IBIAS_A.
.param DESVAR_W1=3
.param DESVAR_L1=0.8
.param DESVAR_W2=4
.param DESVAR_L2=1
.param DESVAR_W3=1.2
.param DESVAR_L3=0.8
.param DESVAR_W4=2
.param DESVAR_L4=0.8
.param DESVAR_W5=5
.param DESVAR_L5=0.6
.param DESVAR_W6=4
.param DESVAR_L6=0.8
.param DESVAR_W7=2
.param DESVAR_L7=0.6
.param DESVAR_W8=4
.param DESVAR_L8=0.8
.param DESVAR_W9=5
.param DESVAR_L9=0.8

.param DESVAR_M1=1
.param DESVAR_M2=2
.param DESVAR_M3=1
.param DESVAR_M4=2
.param DESVAR_M5=2
.param DESVAR_M6=2
.param IBIAS_A=2e-6
