* ============================================================
* opamp0_params.sp
*
* Design parameters for opamp0
*
* Units:
*   W, L    -> um
*   IBIAS_A -> A
*   M       -> dimensionless positive integer
* ============================================================

.param DESVAR_W1=5.0
.param DESVAR_L1=0.5

.param DESVAR_W2=5.0
.param DESVAR_L2=0.5

.param DESVAR_W3=5.0
.param DESVAR_L3=0.5

.param DESVAR_W4=5.0
.param DESVAR_L4=0.5

.param DESVAR_W5=5.0
.param DESVAR_L5=0.5

.param DESVAR_W6=5.0
.param DESVAR_L6=0.5

.param DESVAR_W7=5.0
.param DESVAR_L7=0.5

.param DESVAR_M1=1

.param IBIAS_A=10e-6
