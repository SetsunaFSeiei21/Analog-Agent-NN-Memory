* Two-stage folded-cascode op-amp design parameters.
* W/L: um; current: A; resistance: ohm; capacitance: F.
* M1_FACTOR and M2_FACTOR are positive integer multiplicities.

.param IBIAS_A=10e-6
.param WPBIAS=8
.param LPBIAS=0.5
.param WNBIAS=8
.param LNBIAS=0.5
.param WPCAS_BIAS=8
.param LPCAS_BIAS=0.5
.param WNCAS_BIAS=8
.param LNCAS_BIAS=0.5
.param WIN=20
.param LIN=0.5
.param WPFOLD=40
.param LPFOLD=0.5
.param WPCAS=40
.param LPCAS=0.5
.param WNCAS=20
.param LNCAS=0.5
.param W2P=80
.param L2P=0.5
.param M1_FACTOR=1
.param M2_FACTOR=1
.param RNULL_OHM=10000
.param CCOMP_F=1e-12
