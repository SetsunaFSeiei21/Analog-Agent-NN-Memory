* Five-transistor OTA design parameters.
* IBIAS_A: A; W/L: um; M_FACTOR: positive integer multiplicity.

.param IBIAS_A=10e-6
.param WBIAS=8
.param LBIAS=0.5
.param WIN=20
.param LIN=0.5
.param WLOAD=40
.param LLOAD=0.5
.param M_FACTOR=1
