* OTA and internal bias design parameters
* IBIAS_A uses amperes; SKY130 device-wrapper W/L use micrometers.

.param IBIAS_A=10e-6
.param WBIAS=8
.param LBIAS=0.5
.param WIN=20
.param LIN=0.5
.param WLOAD=40
.param LLOAD=0.5
.param WTAIL=8
.param LTAIL=0.5
