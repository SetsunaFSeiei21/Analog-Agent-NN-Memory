* W/L: um; current: A; resistance: ohm; capacitance: F
.param IBIAS_A=10e-6
.param WBIAS=8
.param LBIAS=0.5
.param WIN=20
.param LIN=0.5
.param WLOAD=40
.param LLOAD=0.5
.param W2P=80
.param L2P=0.5
.param M_TAIL1=1
.param M_TAIL2=1
.param RNULL_OHM=10000
.param CCOMP_F=1e-12
