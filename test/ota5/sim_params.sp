* ============================================================
* sim_params.sp
*
* Common simulation conditions
* ============================================================

* Supply voltage
.param VDD_VAL = 1.8

* Input common-mode voltage
.param VCM_VAL = 0.9

* Tail current-source gate bias
.param VBIAS_VAL = 0.70

* Output load
.param CL_VAL = 1p

* Simulation temperature
.temp 27
