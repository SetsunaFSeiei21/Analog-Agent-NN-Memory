* ============================================================
* ota_params.sp
*
* OTA sizing parameters
*
* Units:
*   W, L -> um
* ============================================================

.param WIN_VAL    = 2.0
.param LIN_VAL    = 0.5

.param WLOAD_VAL  = 44.5
.param LLOAD_VAL  = 0.5

.param WTAIL_VAL  = 2.5
.param LTAIL_VAL  = 0.5
